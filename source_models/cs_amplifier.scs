// NMOS Common-Source Stage

simulator lang=spectre

* device model; download from course website
* include "./cmos180.scs" section tt
include "./source_models/cmos180.scs"
* save transistor bias (gm, cgs, ...); very helpful for diagnosis
save m1

* circuit model
parameters vdd=1.8
parameters vi=510m
parameters ibias=170u

vin (vi 0) vsource dc=vi mag=1
vob (vdd2 0) vsource dc=vdd/2
ib  (vdd2 vo) isource dc=ibias

m1 (vo vi 0 0) nfet l=180n w=26u
rl (vdd2 vo) resistor r=1.41k
cl (vo 0) capacitor c=2.26p

* analysis

options1 options gmin=0.1p reltol=0.1m vabstol=1u iabstol=100ps
options2 options temp=27 tnom=27
options3 options save=allpub rawfmt=psfbin rawfile="./input.raw"

dc1 dc param=vi start=0 stop=[PARAMETER] lin=101
ac1 ac start=100k stop=10G log=101
noise1 (vo 0) noise start=100k stop=1T log=101
